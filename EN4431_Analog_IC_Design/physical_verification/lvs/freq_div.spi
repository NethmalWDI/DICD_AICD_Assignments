* +++++++++++++++++++++++++++++++++++++++++++++++++++++ *
* CDL Netlist:                                          *
*                                                       *
* Cell Name  : freq_div                                 *
* Netlisted  : Sun Jun 21 17:51:06 2026                 *
* PVS Version: 16.10-p006 Thu Jul 27 18:05:02 PDT 2017 *
* +++++++++++++++++++++++++++++++++++++++++++++++++++++ *
*.LDD
*.DEVTMPLT 0 R(res_generic_m1) met1_res met1(P) met1(N)
*.DEVTMPLT 1 R(res_generic_m2) met2_res met2(P) met2(N)
*.DEVTMPLT 2 R(res_generic_m3) met3_res met3(P) met3(N)
*.DEVTMPLT 3 R(res_generic_m4) met4_res met4(P) met4(N)
*.DEVTMPLT 4 R(res_generic_m5) met5_res met5(P) met5(N)
*.DEVTMPLT 5 D(diode_pd2nw_05v5) diode_pd2nw_05v5_rec psd(PLUS) nwell(MINUS)
*.DEVTMPLT 6 D(diode_pd2nw_05v5_hvt) diode_pd2nw_05v5_hvt_rec psd(PLUS) nwell(MINUS)
*.DEVTMPLT 7 D(diode_pd2nw_05v5_lvt) diode_pd2nw_05v5_lvt_rec psd(PLUS) nwell(MINUS)
*.DEVTMPLT 8 D(diode_pd2nw_11v0) diode_pd2nw_11v0_rec psd(PLUS) nwell(MINUS)
*.DEVTMPLT 9 D(diode_pw2nd_05v5) diode_pw2nd_05v5_rec pwell_all(PLUS) nsd(MINUS)
*.DEVTMPLT 10 D(diode_pw2nd_05v5_lvt) diode_pw2nd_05v5_lvt_rec pwell_all(PLUS) nsd(MINUS)
*.DEVTMPLT 11 D(diode_pw2nd_05v5_nvt) diode_pw2nd_05v5_nvt_rec pwell_all(PLUS) nsd(MINUS)
*.DEVTMPLT 12 D(diode_pw2nd_11v0) diode_pw2nd_11v0_rec pwell_all(PLUS) nsd(MINUS)
*.DEVTMPLT 0 R(RES_GENERIC_ND) diff_res np_term(P) np_term(N)
*.DEVTMPLT 1 R(RES_GENERIC_PD) diff_res pp_term(P) pp_term(N)
*.DEVTMPLT 15 MN(nfet_01v8) nfet_01v8_rec nSourceDrain(D) nfet(G) nSourceDrain(S) pwell_all(B)
*.DEVTMPLT 16 MP(pfet_01v8) pfet_01v8_rec pSourceDrain(D) pfet(G) pSourceDrain(S) nwell(B)
*.DEVTMPLT 17 MP(pfet_01v8_lvt) lvtpfet_01v8_rec pSourceDrain(D) lvtpfet(G) pSourceDrain(S) nwell(B)
*.DEVTMPLT 18 MN(nfet_01v8_lvt) lvtnfet_01v8_rec nSourceDrain(D) lvtnfet(G) nSourceDrain(S) pwell_all(B)
*.DEVTMPLT 19 MP(pfet_01v8_hvt) hvtpfet_01v8_rec pSourceDrain(D) hvtpfet(G) pSourceDrain(S) nwell(B)
*.DEVTMPLT 20 MN(nfet_03v3_nvt) HV_ngate_3v3 HV_source_drain(D) HV_FET_gate(G) HV_source_drain(S) pwell_all(B)
*.DEVTMPLT 21 MN(nfet_05v0_nvt) HV_ngate_5v0 HV_source_drain(D) HV_FET_gate(G) HV_source_drain(S) pwell_all(B)
*.DEVTMPLT 22 MN(nfet_g5v0d10v5) HV_ngate_5v10v HV_source_drain(D) HV_FET_gate(G) HV_source_drain(S) pwell_all(B)
*.DEVTMPLT 23 MP(pfet_g5v0d10v5) HV_pgate_5v10v HV_source_drain(D) HV_FET_gate(G) HV_source_drain(S) nwell(B)
*.DEVTMPLT 24 MN(nfet_20v0) nfet_v20_rec nfet_v20_drain(D) nfet_v20_gate(G) nfet_v20_source(S) pwell_all(B)
*.DEVTMPLT 25 MN(nfet_20v0_zvt) nfet_v20_zvt_rec nfet_v20_drain(D) nfet_v20_gate(G) nfet_v20_source(S) pwell_all(B)
*.DEVTMPLT 26 MP(pfet_20v0) pfet_v20_rec pfet_v20_drain(D) pfet_v20_gate(G) pfet_v20_source(S) nwell(B)
*.DEVTMPLT 27 Q(npn_05v5) npn_rec npnC(C) npnB(B) npnE(E) pwell_all(BN)
*.DEVTMPLT 28 Q(npn_11v0) hvnpn_rec npnC(C) npnB(B) hvnpnE(E) pwell_all(BN)
*.DEVTMPLT 29 Q(pnp_05v5) pnp_rec pnpC(C) pnpB(B) pnpE(E) pwell_all(BN)
*.DEVTMPLT 30 R(res_high_po_0p35) res_high_po_0p35_rec prec_resistor_term(PLUS) prec_resistor_term(MINUS) pwell_all(B)
*.DEVTMPLT 31 R(res_high_po_0p69) res_high_po_0p69_rec prec_resistor_term(PLUS) prec_resistor_term(MINUS) pwell_all(B)
*.DEVTMPLT 32 R(res_high_po_1p41) res_high_po_1p41_rec prec_resistor_term(PLUS) prec_resistor_term(MINUS) pwell_all(B)
*.DEVTMPLT 33 R(res_high_po_2p85) res_high_po_2p85_rec prec_resistor_term(PLUS) prec_resistor_term(MINUS) pwell_all(B)
*.DEVTMPLT 34 R(res_high_po_5p73) res_high_po_5p73_rec prec_resistor_term(PLUS) prec_resistor_term(MINUS) pwell_all(B)
*.DEVTMPLT 35 R(res_xhigh_po_0p35) res_xhigh_po_0p35_rec prec_resistor_term(PLUS) prec_resistor_term(MINUS) pwell_all(B)
*.DEVTMPLT 36 R(res_xhigh_po_0p69) res_xhigh_po_0p69_rec prec_resistor_term(PLUS) prec_resistor_term(MINUS) pwell_all(B)
*.DEVTMPLT 37 R(res_xhigh_po_1p41) res_xhigh_po_1p41_rec prec_resistor_term(PLUS) prec_resistor_term(MINUS) pwell_all(B)
*.DEVTMPLT 38 R(res_xhigh_po_2p85) res_xhigh_po_2p85_rec prec_resistor_term(PLUS) prec_resistor_term(MINUS) pwell_all(B)
*.DEVTMPLT 39 R(res_xhigh_po_5p73) res_xhigh_po_5p73_rec prec_resistor_term(PLUS) prec_resistor_term(MINUS) pwell_all(B)
*.DEVTMPLT 40 C(cap_mim_m3__base) capacitor top_plate(PLUS) bottom_plate(MINUS)

* +++++++++++++++++++++++++++++++++++++++++++++++++++++ *
* Sub cell: DFFRX1_LP                                   *
* +++++++++++++++++++++++++++++++++++++++++++++++++++++ *
.subckt DFFRX1_LP CK RN D VDD VSS Q QN
** N=120 EP=7 FDC=32
M0 VSS CK 28 VSS nfet_01v8 L=1.5e-07 W=4.2e-07 $X=860 $Y=590 $dt=15
M1 8 D VSS VSS nfet_01v8 L=1.5e-07 W=4.2e-07 $X=1290 $Y=590 $dt=15
M2 30 28 8 VSS nfet_01v8 L=1.5e-07 W=4.2e-07 $X=1720 $Y=590 $dt=15
M3 12 22 30 VSS nfet_01v8 L=1.5e-07 W=4.2e-07 $X=2150 $Y=590 $dt=15
M4 14 25 12 VSS nfet_01v8 L=1.5e-07 W=4.2e-07 $X=2580 $Y=590 $dt=15
M5 VSS RN 14 VSS nfet_01v8 L=1.5e-07 W=4.2e-07 $X=3010 $Y=590 $dt=15
M6 VSS 28 22 VSS nfet_01v8 L=1.5e-07 W=4.2e-07 $X=3960 $Y=590 $dt=15
M7 25 30 VSS VSS nfet_01v8 L=1.5e-07 W=4.2e-07 $X=4390 $Y=590 $dt=15
M8 36 22 25 VSS nfet_01v8 L=1.5e-07 W=4.2e-07 $X=4820 $Y=590 $dt=15
M9 16 28 36 VSS nfet_01v8 L=1.5e-07 W=4.2e-07 $X=5250 $Y=590 $dt=15
M10 VSS 34 16 VSS nfet_01v8 L=1.5e-07 W=4.2e-07 $X=5680 $Y=590 $dt=15
M11 46 36 34 VSS nfet_01v8 L=1.5e-07 W=4.2e-07 $X=6630 $Y=590 $dt=15
M12 VSS RN 46 VSS nfet_01v8 L=1.5e-07 W=4.2e-07 $X=7060 $Y=590 $dt=15
M13 41 34 VSS VSS nfet_01v8 L=1.5e-07 W=4.2e-07 $X=7490 $Y=590 $dt=15
M14 VSS 34 Q VSS nfet_01v8 L=1.5e-07 W=4.2e-07 $X=8440 $Y=590 $dt=15
M15 QN 41 VSS VSS nfet_01v8 L=1.5e-07 W=4.2e-07 $X=8870 $Y=590 $dt=15
M16 VDD CK 28 VDD pfet_01v8_hvt L=1.5e-07 W=5.4e-07 $X=860 $Y=2925 $dt=19
M17 10 D VDD VDD pfet_01v8_hvt L=1.5e-07 W=5.4e-07 $X=1290 $Y=2925 $dt=19
M18 30 22 10 VDD pfet_01v8_hvt L=1.5e-07 W=5.4e-07 $X=1720 $Y=2925 $dt=19
M19 45 28 30 VDD pfet_01v8_hvt L=1.5e-07 W=5.4e-07 $X=2150 $Y=2925 $dt=19
M20 VDD 25 45 VDD pfet_01v8_hvt L=1.5e-07 W=5.4e-07 $X=2580 $Y=2925 $dt=19
M21 45 RN VDD VDD pfet_01v8_hvt L=1.5e-07 W=5.4e-07 $X=3010 $Y=2925 $dt=19
M22 VDD 28 22 VDD pfet_01v8_hvt L=1.5e-07 W=5.4e-07 $X=3960 $Y=2925 $dt=19
M23 25 30 VDD VDD pfet_01v8_hvt L=1.5e-07 W=5.4e-07 $X=4390 $Y=2925 $dt=19
M24 36 28 25 VDD pfet_01v8_hvt L=1.5e-07 W=5.4e-07 $X=4820 $Y=2925 $dt=19
M25 18 22 36 VDD pfet_01v8_hvt L=1.5e-07 W=5.4e-07 $X=5250 $Y=2925 $dt=19
M26 VDD 34 18 VDD pfet_01v8_hvt L=1.5e-07 W=5.4e-07 $X=5680 $Y=2925 $dt=19
M27 34 36 VDD VDD pfet_01v8_hvt L=1.5e-07 W=5.4e-07 $X=6630 $Y=2925 $dt=19
M28 VDD RN 34 VDD pfet_01v8_hvt L=1.5e-07 W=5.4e-07 $X=7060 $Y=2925 $dt=19
M29 41 34 VDD VDD pfet_01v8_hvt L=1.5e-07 W=5.4e-07 $X=7490 $Y=2925 $dt=19
M30 VDD 34 Q VDD pfet_01v8_hvt L=1.5e-07 W=6.2e-07 $X=8440 $Y=2845 $dt=19
M31 QN 41 VDD VDD pfet_01v8_hvt L=1.5e-07 W=6.2e-07 $X=8870 $Y=2845 $dt=19
.ends DFFRX1_LP

* +++++++++++++++++++++++++++++++++++++++++++++++++++++ *
* Sub cell: AND2X1_LP                                   *
* +++++++++++++++++++++++++++++++++++++++++++++++++++++ *
.subckt AND2X1_LP A B VDD VSS Y
** N=28 EP=5 FDC=6
M0 6 A 10 VSS nfet_01v8 L=1.5e-07 W=4.2e-07 $X=860 $Y=590 $dt=15
M1 VSS B 6 VSS nfet_01v8 L=1.5e-07 W=4.2e-07 $X=1290 $Y=590 $dt=15
M2 Y 10 VSS VSS nfet_01v8 L=1.5e-07 W=4.2e-07 $X=1780 $Y=590 $dt=15
M3 10 A VDD VDD pfet_01v8_hvt L=1.5e-07 W=5.4e-07 $X=860 $Y=3140 $dt=19
M4 VDD B 10 VDD pfet_01v8_hvt L=1.5e-07 W=5.4e-07 $X=1290 $Y=3140 $dt=19
M5 Y 10 VDD VDD pfet_01v8_hvt L=1.5e-07 W=6.2e-07 $X=1780 $Y=3060 $dt=19
.ends AND2X1_LP

* +++++++++++++++++++++++++++++++++++++++++++++++++++++ *
* Sub cell: freq_div                                    *
* +++++++++++++++++++++++++++++++++++++++++++++++++++++ *
.subckt freq_div VDD! VSS! clk_in clk_out rst
** N=17 EP=5 FDC=198
X0 1 rst 3 VDD! VSS! 6 7 DFFRX1_LP $T=4265 8140 0 0 $X=4085 $Y=7875
X1 8 rst 9 VDD! VSS! 10 11 DFFRX1_LP $T=4265 15700 0 0 $X=4085 $Y=15435
X2 clk_in rst 13 VDD! VSS! 14 15 DFFRX1_LP $T=4265 22920 0 0 $X=4085 $Y=22655
X3 1 rst 6 VDD! VSS! clk_out 3 DFFRX1_LP $T=18345 8140 0 0 $X=18165 $Y=7875
X4 8 rst 10 VDD! VSS! 1 9 DFFRX1_LP $T=18345 15700 0 0 $X=18165 $Y=15435
X5 clk_in rst 17 VDD! VSS! 8 13 DFFRX1_LP $T=18345 22920 0 0 $X=18165 $Y=22655
X6 13 14 VDD! VSS! 17 AND2X1_LP $T=32550 16510 0 0 $X=32370 $Y=16245
.ends freq_div
