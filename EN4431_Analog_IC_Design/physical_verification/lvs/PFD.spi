* +++++++++++++++++++++++++++++++++++++++++++++++++++++ *
* CDL Netlist:                                          *
*                                                       *
* Cell Name  : PFD                                      *
* Netlisted  : Sun Jun 21 17:42:44 2026                 *
* PVS Version: 16.10-p006 Thu Jul 27 18:05:02 PDT 2017 *
* +++++++++++++++++++++++++++++++++++++++++++++++++++++ *
*.LDD
*.DEVTMPLT 0 R(res_generic_m1) met1_res met1(P) met1(N)
*.DEVTMPLT 1 R(res_generic_m2) met2_res met2(P) met2(N)
*.DEVTMPLT 2 R(res_generic_m3) met3_res met3(P) met3(N)
*.DEVTMPLT 3 R(res_generic_m4) met4_res met4(P) met4(N)
*.DEVTMPLT 4 R(res_generic_m5) met5_res met5(P) met5(N)
*.DEVTMPLT 5 D(diode_pd2nw_05v5) diode_pd2nw_05v5_rec psd(PLUS) nwell(MINUS)
*.DEVTMPLT 6 D(diode_pd2nw_05v5_hvt) diode_pd2nw_05v5_hvt_rec psd(PLUS) nwell(MINUS)
*.DEVTMPLT 7 D(diode_pd2nw_05v5_lvt) diode_pd2nw_05v5_lvt_rec psd(PLUS) nwell(MINUS)
*.DEVTMPLT 8 D(diode_pd2nw_11v0) diode_pd2nw_11v0_rec psd(PLUS) nwell(MINUS)
*.DEVTMPLT 9 D(diode_pw2nd_05v5) diode_pw2nd_05v5_rec pwell_all(PLUS) nsd(MINUS)
*.DEVTMPLT 10 D(diode_pw2nd_05v5_lvt) diode_pw2nd_05v5_lvt_rec pwell_all(PLUS) nsd(MINUS)
*.DEVTMPLT 11 D(diode_pw2nd_05v5_nvt) diode_pw2nd_05v5_nvt_rec pwell_all(PLUS) nsd(MINUS)
*.DEVTMPLT 12 D(diode_pw2nd_11v0) diode_pw2nd_11v0_rec pwell_all(PLUS) nsd(MINUS)
*.DEVTMPLT 0 R(RES_GENERIC_ND) diff_res np_term(P) np_term(N)
*.DEVTMPLT 1 R(RES_GENERIC_PD) diff_res pp_term(P) pp_term(N)
*.DEVTMPLT 15 MN(nfet_01v8) nfet_01v8_rec nSourceDrain(D) nfet(G) nSourceDrain(S) pwell_all(B)
*.DEVTMPLT 16 MP(pfet_01v8) pfet_01v8_rec pSourceDrain(D) pfet(G) pSourceDrain(S) nwell(B)
*.DEVTMPLT 17 MP(pfet_01v8_lvt) lvtpfet_01v8_rec pSourceDrain(D) lvtpfet(G) pSourceDrain(S) nwell(B)
*.DEVTMPLT 18 MN(nfet_01v8_lvt) lvtnfet_01v8_rec nSourceDrain(D) lvtnfet(G) nSourceDrain(S) pwell_all(B)
*.DEVTMPLT 19 MP(pfet_01v8_hvt) hvtpfet_01v8_rec pSourceDrain(D) hvtpfet(G) pSourceDrain(S) nwell(B)
*.DEVTMPLT 20 MN(nfet_03v3_nvt) HV_ngate_3v3 HV_source_drain(D) HV_FET_gate(G) HV_source_drain(S) pwell_all(B)
*.DEVTMPLT 21 MN(nfet_05v0_nvt) HV_ngate_5v0 HV_source_drain(D) HV_FET_gate(G) HV_source_drain(S) pwell_all(B)
*.DEVTMPLT 22 MN(nfet_g5v0d10v5) HV_ngate_5v10v HV_source_drain(D) HV_FET_gate(G) HV_source_drain(S) pwell_all(B)
*.DEVTMPLT 23 MP(pfet_g5v0d10v5) HV_pgate_5v10v HV_source_drain(D) HV_FET_gate(G) HV_source_drain(S) nwell(B)
*.DEVTMPLT 24 MN(nfet_20v0) nfet_v20_rec nfet_v20_drain(D) nfet_v20_gate(G) nfet_v20_source(S) pwell_all(B)
*.DEVTMPLT 25 MN(nfet_20v0_zvt) nfet_v20_zvt_rec nfet_v20_drain(D) nfet_v20_gate(G) nfet_v20_source(S) pwell_all(B)
*.DEVTMPLT 26 MP(pfet_20v0) pfet_v20_rec pfet_v20_drain(D) pfet_v20_gate(G) pfet_v20_source(S) nwell(B)
*.DEVTMPLT 27 Q(npn_05v5) npn_rec npnC(C) npnB(B) npnE(E) pwell_all(BN)
*.DEVTMPLT 28 Q(npn_11v0) hvnpn_rec npnC(C) npnB(B) hvnpnE(E) pwell_all(BN)
*.DEVTMPLT 29 Q(pnp_05v5) pnp_rec pnpC(C) pnpB(B) pnpE(E) pwell_all(BN)
*.DEVTMPLT 30 R(res_high_po_0p35) res_high_po_0p35_rec prec_resistor_term(PLUS) prec_resistor_term(MINUS) pwell_all(B)
*.DEVTMPLT 31 R(res_high_po_0p69) res_high_po_0p69_rec prec_resistor_term(PLUS) prec_resistor_term(MINUS) pwell_all(B)
*.DEVTMPLT 32 R(res_high_po_1p41) res_high_po_1p41_rec prec_resistor_term(PLUS) prec_resistor_term(MINUS) pwell_all(B)
*.DEVTMPLT 33 R(res_high_po_2p85) res_high_po_2p85_rec prec_resistor_term(PLUS) prec_resistor_term(MINUS) pwell_all(B)
*.DEVTMPLT 34 R(res_high_po_5p73) res_high_po_5p73_rec prec_resistor_term(PLUS) prec_resistor_term(MINUS) pwell_all(B)
*.DEVTMPLT 35 R(res_xhigh_po_0p35) res_xhigh_po_0p35_rec prec_resistor_term(PLUS) prec_resistor_term(MINUS) pwell_all(B)
*.DEVTMPLT 36 R(res_xhigh_po_0p69) res_xhigh_po_0p69_rec prec_resistor_term(PLUS) prec_resistor_term(MINUS) pwell_all(B)
*.DEVTMPLT 37 R(res_xhigh_po_1p41) res_xhigh_po_1p41_rec prec_resistor_term(PLUS) prec_resistor_term(MINUS) pwell_all(B)
*.DEVTMPLT 38 R(res_xhigh_po_2p85) res_xhigh_po_2p85_rec prec_resistor_term(PLUS) prec_resistor_term(MINUS) pwell_all(B)
*.DEVTMPLT 39 R(res_xhigh_po_5p73) res_xhigh_po_5p73_rec prec_resistor_term(PLUS) prec_resistor_term(MINUS) pwell_all(B)
*.DEVTMPLT 40 C(cap_mim_m3__base) capacitor top_plate(PLUS) bottom_plate(MINUS)

* +++++++++++++++++++++++++++++++++++++++++++++++++++++ *
* Sub cell: DFFRX1_LP                                   *
* +++++++++++++++++++++++++++++++++++++++++++++++++++++ *
.subckt DFFRX1_LP CK RN D VDD VSS Q QN
** N=120 EP=7 FDC=32
M0 VSS CK 48 VSS nfet_01v8 L=1.5e-07 W=4.2e-07 $X=860 $Y=590 $dt=15
M1 28 D VSS VSS nfet_01v8 L=1.5e-07 W=4.2e-07 $X=1290 $Y=590 $dt=15
M2 50 48 28 VSS nfet_01v8 L=1.5e-07 W=4.2e-07 $X=1720 $Y=590 $dt=15
M3 32 42 50 VSS nfet_01v8 L=1.5e-07 W=4.2e-07 $X=2150 $Y=590 $dt=15
M4 34 45 32 VSS nfet_01v8 L=1.5e-07 W=4.2e-07 $X=2580 $Y=590 $dt=15
M5 VSS RN 34 VSS nfet_01v8 L=1.5e-07 W=4.2e-07 $X=3010 $Y=590 $dt=15
M6 VSS 48 42 VSS nfet_01v8 L=1.5e-07 W=4.2e-07 $X=3960 $Y=590 $dt=15
M7 45 50 VSS VSS nfet_01v8 L=1.5e-07 W=4.2e-07 $X=4390 $Y=590 $dt=15
M8 56 42 45 VSS nfet_01v8 L=1.5e-07 W=4.2e-07 $X=4820 $Y=590 $dt=15
M9 36 48 56 VSS nfet_01v8 L=1.5e-07 W=4.2e-07 $X=5250 $Y=590 $dt=15
M10 VSS 54 36 VSS nfet_01v8 L=1.5e-07 W=4.2e-07 $X=5680 $Y=590 $dt=15
M11 66 56 54 VSS nfet_01v8 L=1.5e-07 W=4.2e-07 $X=6630 $Y=590 $dt=15
M12 VSS RN 66 VSS nfet_01v8 L=1.5e-07 W=4.2e-07 $X=7060 $Y=590 $dt=15
M13 61 54 VSS VSS nfet_01v8 L=1.5e-07 W=4.2e-07 $X=7490 $Y=590 $dt=15
M14 VSS 54 Q VSS nfet_01v8 L=1.5e-07 W=4.2e-07 $X=8440 $Y=590 $dt=15
M15 QN 61 VSS VSS nfet_01v8 L=1.5e-07 W=4.2e-07 $X=8870 $Y=590 $dt=15
M16 VDD CK 48 VDD pfet_01v8_hvt L=1.5e-07 W=5.4e-07 $X=860 $Y=2925 $dt=19
M17 30 D VDD VDD pfet_01v8_hvt L=1.5e-07 W=5.4e-07 $X=1290 $Y=2925 $dt=19
M18 50 42 30 VDD pfet_01v8_hvt L=1.5e-07 W=5.4e-07 $X=1720 $Y=2925 $dt=19
M19 65 48 50 VDD pfet_01v8_hvt L=1.5e-07 W=5.4e-07 $X=2150 $Y=2925 $dt=19
M20 VDD 45 65 VDD pfet_01v8_hvt L=1.5e-07 W=5.4e-07 $X=2580 $Y=2925 $dt=19
M21 65 RN VDD VDD pfet_01v8_hvt L=1.5e-07 W=5.4e-07 $X=3010 $Y=2925 $dt=19
M22 VDD 48 42 VDD pfet_01v8_hvt L=1.5e-07 W=5.4e-07 $X=3960 $Y=2925 $dt=19
M23 45 50 VDD VDD pfet_01v8_hvt L=1.5e-07 W=5.4e-07 $X=4390 $Y=2925 $dt=19
M24 56 48 45 VDD pfet_01v8_hvt L=1.5e-07 W=5.4e-07 $X=4820 $Y=2925 $dt=19
M25 38 42 56 VDD pfet_01v8_hvt L=1.5e-07 W=5.4e-07 $X=5250 $Y=2925 $dt=19
M26 VDD 54 38 VDD pfet_01v8_hvt L=1.5e-07 W=5.4e-07 $X=5680 $Y=2925 $dt=19
M27 54 56 VDD VDD pfet_01v8_hvt L=1.5e-07 W=5.4e-07 $X=6630 $Y=2925 $dt=19
M28 VDD RN 54 VDD pfet_01v8_hvt L=1.5e-07 W=5.4e-07 $X=7060 $Y=2925 $dt=19
M29 61 54 VDD VDD pfet_01v8_hvt L=1.5e-07 W=5.4e-07 $X=7490 $Y=2925 $dt=19
M30 VDD 54 Q VDD pfet_01v8_hvt L=1.5e-07 W=6.2e-07 $X=8440 $Y=2845 $dt=19
M31 QN 61 VDD VDD pfet_01v8_hvt L=1.5e-07 W=6.2e-07 $X=8870 $Y=2845 $dt=19
.ends DFFRX1_LP

* +++++++++++++++++++++++++++++++++++++++++++++++++++++ *
* Sub cell: NAND2X1_LP                                  *
* +++++++++++++++++++++++++++++++++++++++++++++++++++++ *
.subckt NAND2X1_LP A B Y VDD VSS
** N=22 EP=5 FDC=4
M0 8 A VSS VSS nfet_01v8 L=1.5e-07 W=4.2e-07 $X=860 $Y=590 $dt=15
M1 Y B 8 VSS nfet_01v8 L=1.5e-07 W=4.2e-07 $X=1290 $Y=590 $dt=15
M2 Y A VDD VDD pfet_01v8_hvt L=1.5e-07 W=6.2e-07 $X=860 $Y=2935 $dt=19
M3 VDD B Y VDD pfet_01v8_hvt L=1.5e-07 W=6.2e-07 $X=1290 $Y=2935 $dt=19
.ends NAND2X1_LP

* +++++++++++++++++++++++++++++++++++++++++++++++++++++ *
* Sub cell: PFD                                         *
* +++++++++++++++++++++++++++++++++++++++++++++++++++++ *
.subckt PFD Qa Qb VDD! VSS! vdd vfb vref
** N=30 EP=7 FDC=68
X17 vfb 4 vdd VDD! VSS! Qb 9 DFFRX1_LP $T=1005 6970 1 0 $X=825 $Y=2525
X18 vref 4 vdd VDD! VSS! Qa 30 DFFRX1_LP $T=1005 6970 0 0 $X=825 $Y=6705
X19 Qb Qa 4 VDD! VSS! NAND2X1_LP $T=15510 9030 0 180 $X=13030 $Y=4585
.ends PFD
