* +++++++++++++++++++++++++++++++++++++++++++++++++++++ *
* CDL Netlist:                                          *
*                                                       *
* Cell Name  : Current_trarved_ring_VCO                 *
* Netlisted  : Sun Jun 21 17:51:31 2026                 *
* PVS Version: 16.10-p006 Thu Jul 27 18:05:02 PDT 2017 *
* +++++++++++++++++++++++++++++++++++++++++++++++++++++ *
*.LDD
*.DEVTMPLT 0 R(res_generic_m1) met1_res met1(P) met1(N)
*.DEVTMPLT 1 R(res_generic_m2) met2_res met2(P) met2(N)
*.DEVTMPLT 2 R(res_generic_m3) met3_res met3(P) met3(N)
*.DEVTMPLT 3 R(res_generic_m4) met4_res met4(P) met4(N)
*.DEVTMPLT 4 R(res_generic_m5) met5_res met5(P) met5(N)
*.DEVTMPLT 5 D(diode_pd2nw_05v5) diode_pd2nw_05v5_rec psd(PLUS) nwell(MINUS)
*.DEVTMPLT 6 D(diode_pd2nw_05v5_hvt) diode_pd2nw_05v5_hvt_rec psd(PLUS) nwell(MINUS)
*.DEVTMPLT 7 D(diode_pd2nw_05v5_lvt) diode_pd2nw_05v5_lvt_rec psd(PLUS) nwell(MINUS)
*.DEVTMPLT 8 D(diode_pd2nw_11v0) diode_pd2nw_11v0_rec psd(PLUS) nwell(MINUS)
*.DEVTMPLT 9 D(diode_pw2nd_05v5) diode_pw2nd_05v5_rec pwell_all(PLUS) nsd(MINUS)
*.DEVTMPLT 10 D(diode_pw2nd_05v5_lvt) diode_pw2nd_05v5_lvt_rec pwell_all(PLUS) nsd(MINUS)
*.DEVTMPLT 11 D(diode_pw2nd_05v5_nvt) diode_pw2nd_05v5_nvt_rec pwell_all(PLUS) nsd(MINUS)
*.DEVTMPLT 12 D(diode_pw2nd_11v0) diode_pw2nd_11v0_rec pwell_all(PLUS) nsd(MINUS)
*.DEVTMPLT 0 R(RES_GENERIC_ND) diff_res np_term(P) np_term(N)
*.DEVTMPLT 1 R(RES_GENERIC_PD) diff_res pp_term(P) pp_term(N)
*.DEVTMPLT 15 MN(nfet_01v8) nfet_01v8_rec nSourceDrain(D) nfet(G) nSourceDrain(S) pwell_all(B)
*.DEVTMPLT 16 MP(pfet_01v8) pfet_01v8_rec pSourceDrain(D) pfet(G) pSourceDrain(S) nwell(B)
*.DEVTMPLT 17 MP(pfet_01v8_lvt) lvtpfet_01v8_rec pSourceDrain(D) lvtpfet(G) pSourceDrain(S) nwell(B)
*.DEVTMPLT 18 MN(nfet_01v8_lvt) lvtnfet_01v8_rec nSourceDrain(D) lvtnfet(G) nSourceDrain(S) pwell_all(B)
*.DEVTMPLT 19 MP(pfet_01v8_hvt) hvtpfet_01v8_rec pSourceDrain(D) hvtpfet(G) pSourceDrain(S) nwell(B)
*.DEVTMPLT 20 MN(nfet_03v3_nvt) HV_ngate_3v3 HV_source_drain(D) HV_FET_gate(G) HV_source_drain(S) pwell_all(B)
*.DEVTMPLT 21 MN(nfet_05v0_nvt) HV_ngate_5v0 HV_source_drain(D) HV_FET_gate(G) HV_source_drain(S) pwell_all(B)
*.DEVTMPLT 22 MN(nfet_g5v0d10v5) HV_ngate_5v10v HV_source_drain(D) HV_FET_gate(G) HV_source_drain(S) pwell_all(B)
*.DEVTMPLT 23 MP(pfet_g5v0d10v5) HV_pgate_5v10v HV_source_drain(D) HV_FET_gate(G) HV_source_drain(S) nwell(B)
*.DEVTMPLT 24 MN(nfet_20v0) nfet_v20_rec nfet_v20_drain(D) nfet_v20_gate(G) nfet_v20_source(S) pwell_all(B)
*.DEVTMPLT 25 MN(nfet_20v0_zvt) nfet_v20_zvt_rec nfet_v20_drain(D) nfet_v20_gate(G) nfet_v20_source(S) pwell_all(B)
*.DEVTMPLT 26 MP(pfet_20v0) pfet_v20_rec pfet_v20_drain(D) pfet_v20_gate(G) pfet_v20_source(S) nwell(B)
*.DEVTMPLT 27 Q(npn_05v5) npn_rec npnC(C) npnB(B) npnE(E) pwell_all(BN)
*.DEVTMPLT 28 Q(npn_11v0) hvnpn_rec npnC(C) npnB(B) hvnpnE(E) pwell_all(BN)
*.DEVTMPLT 29 Q(pnp_05v5) pnp_rec pnpC(C) pnpB(B) pnpE(E) pwell_all(BN)
*.DEVTMPLT 30 R(res_high_po_0p35) res_high_po_0p35_rec prec_resistor_term(PLUS) prec_resistor_term(MINUS) pwell_all(B)
*.DEVTMPLT 31 R(res_high_po_0p69) res_high_po_0p69_rec prec_resistor_term(PLUS) prec_resistor_term(MINUS) pwell_all(B)
*.DEVTMPLT 32 R(res_high_po_1p41) res_high_po_1p41_rec prec_resistor_term(PLUS) prec_resistor_term(MINUS) pwell_all(B)
*.DEVTMPLT 33 R(res_high_po_2p85) res_high_po_2p85_rec prec_resistor_term(PLUS) prec_resistor_term(MINUS) pwell_all(B)
*.DEVTMPLT 34 R(res_high_po_5p73) res_high_po_5p73_rec prec_resistor_term(PLUS) prec_resistor_term(MINUS) pwell_all(B)
*.DEVTMPLT 35 R(res_xhigh_po_0p35) res_xhigh_po_0p35_rec prec_resistor_term(PLUS) prec_resistor_term(MINUS) pwell_all(B)
*.DEVTMPLT 36 R(res_xhigh_po_0p69) res_xhigh_po_0p69_rec prec_resistor_term(PLUS) prec_resistor_term(MINUS) pwell_all(B)
*.DEVTMPLT 37 R(res_xhigh_po_1p41) res_xhigh_po_1p41_rec prec_resistor_term(PLUS) prec_resistor_term(MINUS) pwell_all(B)
*.DEVTMPLT 38 R(res_xhigh_po_2p85) res_xhigh_po_2p85_rec prec_resistor_term(PLUS) prec_resistor_term(MINUS) pwell_all(B)
*.DEVTMPLT 39 R(res_xhigh_po_5p73) res_xhigh_po_5p73_rec prec_resistor_term(PLUS) prec_resistor_term(MINUS) pwell_all(B)
*.DEVTMPLT 40 C(cap_mim_m3__base) capacitor top_plate(PLUS) bottom_plate(MINUS)

* +++++++++++++++++++++++++++++++++++++++++++++++++++++ *
* Sub cell: pfet_01v8_lvt$$13                           *
* +++++++++++++++++++++++++++++++++++++++++++++++++++++ *
.subckt pfet_01v8_lvt$$13 1 2 3
** N=98 EP=3 FDC=1
M0 3 1 2 2 pfet_01v8_lvt L=1e-06 W=1.6e-05 $X=0 $Y=0 $dt=17
.ends pfet_01v8_lvt$$13

* +++++++++++++++++++++++++++++++++++++++++++++++++++++ *
* Sub cell: pfet_01v8_lvt$$14                           *
* +++++++++++++++++++++++++++++++++++++++++++++++++++++ *
.subckt pfet_01v8_lvt$$14 1 2 3 5
** N=39 EP=4 FDC=1
M0 3 1 2 5 pfet_01v8_lvt L=1e-06 W=6e-06 $X=0 $Y=0 $dt=17
.ends pfet_01v8_lvt$$14

* +++++++++++++++++++++++++++++++++++++++++++++++++++++ *
* Sub cell: nfet_01v8_lvt$$15                           *
* +++++++++++++++++++++++++++++++++++++++++++++++++++++ *
.subckt nfet_01v8_lvt$$15 1 2 3 4
** N=20 EP=4 FDC=1
M0 3 1 2 4 nfet_01v8_lvt L=1e-06 W=3e-06 $X=0 $Y=0 $dt=18
.ends nfet_01v8_lvt$$15

* +++++++++++++++++++++++++++++++++++++++++++++++++++++ *
* Sub cell: nfet_01v8_lvt$$16                           *
* +++++++++++++++++++++++++++++++++++++++++++++++++++++ *
.subckt nfet_01v8_lvt$$16 1 2 3
** N=49 EP=3 FDC=1
M0 3 1 2 2 nfet_01v8_lvt L=1e-06 W=8e-06 $X=0 $Y=0 $dt=18
.ends nfet_01v8_lvt$$16

* +++++++++++++++++++++++++++++++++++++++++++++++++++++ *
* Sub cell: pfet_01v8_lvt$$17                           *
* +++++++++++++++++++++++++++++++++++++++++++++++++++++ *
.subckt pfet_01v8_lvt$$17 1 2
** N=49 EP=2 FDC=1
M0 1 1 2 2 pfet_01v8_lvt L=1e-06 W=8e-06 $X=0 $Y=0 $dt=17
.ends pfet_01v8_lvt$$17

* +++++++++++++++++++++++++++++++++++++++++++++++++++++ *
* Sub cell: nfet_01v8_lvt$$18                           *
* +++++++++++++++++++++++++++++++++++++++++++++++++++++ *
.subckt nfet_01v8_lvt$$18 1 2 3
** N=315 EP=3 FDC=5
M0 3 1 2 2 nfet_01v8_lvt L=1e-06 W=1.8e-05 $X=0 $Y=0 $dt=18
M1 2 1 3 2 nfet_01v8_lvt L=1e-06 W=1.8e-05 $X=1280 $Y=0 $dt=18
M2 3 1 2 2 nfet_01v8_lvt L=1e-06 W=1.8e-05 $X=2560 $Y=0 $dt=18
M3 2 1 3 2 nfet_01v8_lvt L=1e-06 W=1.8e-05 $X=3840 $Y=0 $dt=18
M4 3 1 2 2 nfet_01v8_lvt L=1e-06 W=1.8e-05 $X=5120 $Y=0 $dt=18
.ends nfet_01v8_lvt$$18

* +++++++++++++++++++++++++++++++++++++++++++++++++++++ *
* Sub cell: Current_trarved_ring_VCO                    *
* +++++++++++++++++++++++++++++++++++++++++++++++++++++ *
.subckt Current_trarved_ring_VCO vdd vin vout vss
** N=22 EP=4 FDC=30
X36 4 vdd 5 pfet_01v8_lvt$$13 $T=12015 36065 0 0 $X=11570 $Y=35885
X37 4 vdd 12 pfet_01v8_lvt$$13 $T=18340 36065 0 0 $X=17895 $Y=35885
X38 4 vdd 13 pfet_01v8_lvt$$13 $T=23180 36065 0 0 $X=22735 $Y=35885
X39 4 vdd 14 pfet_01v8_lvt$$13 $T=28025 36065 0 0 $X=27580 $Y=35885
X40 4 vdd 15 pfet_01v8_lvt$$13 $T=33405 36065 0 0 $X=32960 $Y=35885
X41 4 vdd 16 pfet_01v8_lvt$$13 $T=38245 36065 0 0 $X=37800 $Y=35885
X42 10 12 6 vdd pfet_01v8_lvt$$14 $T=18340 26940 0 0 $X=17895 $Y=26760
X43 6 13 7 vdd pfet_01v8_lvt$$14 $T=23180 26940 0 0 $X=22735 $Y=26760
X44 7 14 8 vdd pfet_01v8_lvt$$14 $T=28025 26940 0 0 $X=27580 $Y=26760
X45 8 15 9 vdd pfet_01v8_lvt$$14 $T=33405 26940 0 0 $X=32960 $Y=26760
X46 9 16 10 vdd pfet_01v8_lvt$$14 $T=38245 26940 0 0 $X=37800 $Y=26760
X47 10 vdd vout vdd pfet_01v8_lvt$$14 $T=43220 26950 0 0 $X=42775 $Y=26770
X48 10 17 6 vss nfet_01v8_lvt$$15 $T=18340 19565 0 0 $X=17895 $Y=19385
X49 6 18 7 vss nfet_01v8_lvt$$15 $T=23180 19565 0 0 $X=22735 $Y=19385
X50 7 19 8 vss nfet_01v8_lvt$$15 $T=28025 19565 0 0 $X=27580 $Y=19385
X51 8 20 9 vss nfet_01v8_lvt$$15 $T=33405 19565 0 0 $X=32960 $Y=19385
X52 9 21 10 vss nfet_01v8_lvt$$15 $T=38245 19565 0 0 $X=37800 $Y=19385
X53 10 vss vout vss nfet_01v8_lvt$$15 $T=43220 19630 0 0 $X=42775 $Y=19450
X54 5 vss 5 nfet_01v8_lvt$$16 $T=12015 9530 0 0 $X=11570 $Y=9350
X55 5 vss 17 nfet_01v8_lvt$$16 $T=18340 9420 0 0 $X=17895 $Y=9240
X56 5 vss 18 nfet_01v8_lvt$$16 $T=23180 9420 0 0 $X=22735 $Y=9240
X57 5 vss 19 nfet_01v8_lvt$$16 $T=28025 9420 0 0 $X=27580 $Y=9240
X58 5 vss 20 nfet_01v8_lvt$$16 $T=33405 9420 0 0 $X=32960 $Y=9240
X59 5 vss 21 nfet_01v8_lvt$$16 $T=38245 9420 0 0 $X=37800 $Y=9240
X60 4 vdd pfet_01v8_lvt$$17 $T=6370 44105 0 0 $X=5925 $Y=43925
X61 vin vss 4 nfet_01v8_lvt$$18 $T=3810 4675 0 0 $X=3365 $Y=4495
.ends Current_trarved_ring_VCO
